ADE simulation setup
Test TEST1: morpheus_tests/opamp_AUTO_TB/OPAMP_Open_Loop, simulator spectre
  Variables: VCC = 3.8; VDD = -3.8
  Temperature: 27
  Analysis dc: sweep temperature start=-40 stop=125
  Output EQUATION_1 = value(IS("/V_vcc/MINUS") 27)
  Output Open Loop Gain = value(IS("/V_vcc/MINUS") 27)
Run mode: Single Run, Sweeps and Corners
Global variables:
  VDD = -3.8
  VCC = 3.8
Corners:
  corner1: DATA_path=default; CLK_path=default; VIO_path=default
  corner2: DATA_path=default; CLK_path=default; VIO_path=default
