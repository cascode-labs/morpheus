ADE simulation setup
Test TEST1: morpheus_tests/opamp_AUTO_TB/OPAMP_Open_Loop, simulator spectre
  Variables: VCC = 3.8; VDD = -3.8
  Temperature: 27
  Analysis dc: sweep temperature start=-40 stop=125
  Output EQUATION_1 = value(IS("/V_vcc/MINUS") 27)
  Output Open Loop Gain = value(IS("/V_vcc/MINUS") 27)
Test feedback: morpheus_tests/opamp_AUTO_TB/OPAMP_Feedback, simulator spectre
  Temperature: 27
  Analysis ac: start=0 stop=10000
  Output Open Loop Gain = value(IS("/V_vo/MINUS") 27)
