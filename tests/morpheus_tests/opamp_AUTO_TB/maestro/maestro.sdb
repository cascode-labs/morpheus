ADE simulation setup
Global variables:
  VDD = -3.8
  VCC = 3.8
Corners:
  corner1: DATA_path=default; CLK_path=default; VIO_path=default
  corner2: DATA_path=default; CLK_path=default; VIO_path=default
