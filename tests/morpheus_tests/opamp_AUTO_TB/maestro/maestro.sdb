ADE simulation setup
Run mode: Single Run, Sweeps and Corners
Tests:
  TEST1: morpheus_tests/opamp_AUTO_TB/schematic_OPAMP, simulator spectre
    Variables: VDD = -3.8; VCC = 3.8
Global variables:
  VDD = -3.8
  VCC = 3.8
Corners:
  corner1: DATA_path=default; CLK_path=default; VIO_path=default
  corner2: DATA_path=default; CLK_path=default; VIO_path=default
