ADE simulation setup
Run mode: Single Run, Sweeps and Corners
Tests:
  TEST1: morpheus_tests/opamp_AUTO_TB/OPAMP_Open_Loop, simulator spectre
    Variables: VDD = -3.8; VCC = 3.8
  feedback: morpheus_tests/opamp_AUTO_TB/OPAMP_Feedback, simulator spectre
Global variables:
  VDD = -3.8
  VCC = 3.8
Corners:
  corner1: temp=temp; temp2=temp2
